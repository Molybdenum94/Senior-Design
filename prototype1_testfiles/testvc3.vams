module testvc3;
analog begin
integer x,y,z;
x = 1;
y = 2;
z = 3;
if(x<z)begin
x = x + z;
end
else begin
x = z - x;
end
end
endmodule
