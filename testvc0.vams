module testcv0;
analog begin
integer a;
string b;
a = 1;
function_a(1,a);
b = "Hello World";
$display("%s",b);
end
endmodule
