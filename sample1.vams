module sample1();

task assignment;
input [1:0] x;
output [1:0] y;
begin
	x = 1;
	y = x;
	x = 0;
end
endtask

endmodule
